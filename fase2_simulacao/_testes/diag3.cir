* diag3: assentamento sem IC nenhum (uic, tudo zero) - quanto tempo?
V1 vin 0 19.8
Vg1 g1 0 PULSE(0 1 0 1p 1p 1.212u 2u)
Vg2 g2 0 PULSE(0 1 1.212u 1p 1p 788n 2u)
S1 vin sw g1 0 SWQ
S2 0 sw g2 0 SWQ
.model SWQ SW(Ron=1m Roff=1meg Vt=0.5 Vh=0)
L1 sw out 89u
C1 out 0 44u
Rl out 0 20
.tran 20n 20m 0 20n uic
.meas tran a5  AVG v(out) FROM=4990u TO=5000u
.meas tran a10 AVG v(out) FROM=9990u TO=10000u
.meas tran a15 AVG v(out) FROM=14990u TO=15000u
.meas tran a20 AVG v(out) FROM=19990u TO=20000u
.end
