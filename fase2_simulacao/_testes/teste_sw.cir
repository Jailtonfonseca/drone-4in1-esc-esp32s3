* teste S-model switch + uic/.ic + corrente de indutor em .meas
V1 vin 0 19.8
Vg1 g1 0 PULSE(0 1 0 1p 1p 1.212u 2u)
Vg2 g2 0 PULSE(0 1 1.212u 1p 1p 788n 2u)
S1 vin sw g1 0 SWQ
S2 0 sw g2 0 SWQ
.model SWQ SW(Ron=1m Roff=1meg Vt=0.5 Vh=0)
L1 sw out 89u ic=0.6
C1 out 0 44u
Rl out 0 20
.ic v(out)=11.98
.tran 20n 20u uic
.meas tran v_at_0 FIND v(out) AT=0
.meas tran vout_avg AVG v(out) FROM=10u TO=20u
.meas tran il_pp PP i(L1) FROM=10u TO=20u
.print tran v(out) v(sw)
.end
